ADE simulation setup
Run mode: Monte Carlo Sampling
Tests:
  Project1:COMP_CML:1: Project1/COMP_CML/schematic, simulator spectre
    Outputs: value(VT("/VOS_R") ymax(xval(VT("/VOS_R")))); value(VT("/VOS_F") ymax(xval(VT("/VOS_F")))); delay(?wf1 VT("/CLK") ?value1 0.5 ?edge1 "rising" ?nth1 1 ?td1 0 ?wf2 abs((VT("/XICOMP/VOUTP") - VT("/XICOMP/VOUTN"))) ?value2 0.5 ?edge2 "either" ?nth2 1 ?td2 nil ?stop nil ?multiple nil); delay(?wf1 VT("/VINP") ?value1 0.6 ?edge1 "rising" ?nth1 1 ?td1 0 ?wf2 abs((VT("/XICOMP/VOUTP") - VT("/XICOMP/VOUTN"))) ?value2 0.5 ?edge2 "either" ?nth2 1 ?td2 nil ?stop nil ?multiple nil); nil; delay(?wf1 VT("/VINP") ?value1 0.57 ?edge1 "rising" ?nth1 1 ?td1 0 ?wf2 abs((VT("/VOUTP2") (- VT("/VOUTN2")))) ?value2 0.82 ?edge2 "either" ?nth2 1 ?td2 nil ?stop nil ?multiple nil); delay(?wf1 VT("/VINP") ?value1 0.57 ?edge1 "rising" ?nth1 1 ?td1 0 ?wf2 abs((VT("/VOUTP2") - (VT("/VOUTN2")))) ?value2 0.82 ?edge2 "either" ?nth2 1 ?td2 nil ?stop nil ?multiple nil); delay(?wf1 VT("/VINP") ?value1 0.57 ?edge1 "rising" ?nth1 1 ?td1 0 ?wf2 abs((VT("/VOUTP2") - (VT("/VOUTN2")))) ?value2 0.6 ?edge2 "either" ?nth2 1 ?td2 nil ?stop nil ?multiple nil)
Global variables:
  PER = 0.1n
  VSENS = 1m
  VX = 350m
  CM = 1000m
  L_REG = 60n
  RL = 6k
  LIN = 70n
  WIN = 1u
  W_REG = 250n
  M_CLK = 10
  W_clk = 240n
  ISS = 250u
  L_clk = 60n
  L_tail = 2u
  W_tail = 250u
  N = 1
  W_LARGE = 1u
  W_SMALL = 120n
  iss = 100u
Monte Carlo Sampling options: mcmethod=mismatch, mcnumpoints=200
