ADE simulation setup
Run mode: Single Run, Sweeps and Corners
Tests:
  pro_2:CTLE-TB:1: pro_2/CTLE-TB/schematic, simulator spectre
Global variables:
  CONT_1 = 0:1
  CONT_2 = 0:1
  CONT_3 = 0:1
  VCM = 0.7
  VDD = 1.2
