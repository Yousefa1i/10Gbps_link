ADE simulation setup
Run mode: Single Run, Sweeps and Corners
Tests:
  Project_1_GP2025:DEMUX_TB:1: Project_1_GP2025/DEMUX_TB/schematic, simulator spectre
    Outputs: Q0P
Global variables:
  PER = 0.1n
  ISS = 25u
  M_2nd = 16
  M_CLK = 65
  M_IN = 16
  RD = 1k
  vh = 1.2
  vl = 0
  W_MN1 = 1.2u
  W_MN2 = 1u
  W_MN3 = 1.5u
  W_MP1 = 3.6u
  W_MP2 = 9u
  W_MP3 = 3.6u
  W_MP4 = 3u
  INV_MN = 25
  INV_MP = INV_MN
  L_INV_N = 60n
  L_INV_P = 60n
  TSPC_MN = 20
  TSPC_MP = 40
  L_2nd = 60n
  L_CLK = 60n
  L_IN = L_2nd
  vhigh = 1.2
  vlow = 0
  FO = 1
  D = 0:0.1n:0.7n
