ADE simulation setup
Run mode: Single Run, Sweeps and Corners
Tests:
  Project1:DFE_A:1: Project1/DFE_A/schematic, simulator spectre
