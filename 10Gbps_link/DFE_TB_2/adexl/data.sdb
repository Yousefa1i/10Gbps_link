ADE simulation setup
Run mode: Single Run, Sweeps and Corners
Tests:
  Project1:DFE_TB:1: Project1/DFE_TB/schematic, simulator spectre
Global variables:
  CTRL0 = 1.2,0
  CTRL1 = 1.2,0
  CTRL2 = 0
  CTRL3 = 0
  CTRL_M0 = 1.2,0
  CTRL_M1 = 1.2,0
  CTRL_M2 = 0
  CTRL_M3 = 0
  PER = 0.1n
  SgnP = 1
  RL = 400
  M_TAIL = 18
  RD = 500
