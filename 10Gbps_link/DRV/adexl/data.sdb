ADE simulation setup
Run mode: Single Run, Sweeps and Corners
Tests:
  Proj_1:DRV:1: Proj_1/DRV/schematic, simulator spectre
Global variables:
  Mdown = 144.66
  MUP = 200
Corners:
  C5 (off): R=2000:100:3000
  C6 (off): R=2000:100:3000
  C7 (off): R=2000:100:3000
  C8 (off): R=2000:100:3000
  C9 (off): R=2000:100:3000
