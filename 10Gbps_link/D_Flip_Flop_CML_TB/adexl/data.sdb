ADE simulation setup
Run mode: Single Run, Sweeps and Corners
Tests:
  Project1:D_Flip_Flop_CML_TB:1: Project1/D_Flip_Flop_CML_TB/schematic, simulator spectre
Global variables:
  PER = 0.1n
  M = 1
  MFF = 1
