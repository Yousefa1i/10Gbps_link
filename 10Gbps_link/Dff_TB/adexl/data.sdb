ADE simulation setup
Run mode: Single Run, Sweeps and Corners
Tests:
  Proj_1:Dff_TB:1: Proj_1/Dff_TB/schematic, simulator spectre
