ADE simulation setup
Run mode: Single Run, Sweeps and Corners
Tests:
  Proj_1:MUX_8to1:1: Proj_1/MUX_8to1/schematic, simulator spectre
Global variables:
  vh = 1.2
  vl = 0
