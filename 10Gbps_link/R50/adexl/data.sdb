ADE simulation setup
Run mode: Single Run, Sweeps and Corners
Tests:
  Project1:R50:1: Project1/R50/schematic, simulator spectre
Global variables:
  E0 = 0
  E1 = 0
  E2 = 0
  E3 = 0
  E4 = 0
  E5 = 1
  ISS = 50u
  M_2nd = 6
  M_CLK = 60
  M_IN = 15
  PER = 0.1n
  RD = 1k
  W = 2.94u
  Wp = 2.5u
