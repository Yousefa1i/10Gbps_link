ADE simulation setup
Run mode: Single Run, Sweeps and Corners
Tests:
  serdes_project:RX:1: serdes_project/RX/schematic, simulator spectre
Global variables:
  CTRL0 = 1.2
  CTRL1 = 0
  CTRL2 = 0
  CTRL3 = 0
  E0 = 1
  E1 = 0
  E2 = 0
  E3 = 0
  E4 = 0
  E5 = 0
  M = 8
  M_3rd_Stage = 8
  M_MUX = 1
  M_predriver = 30
  M_TG = 1
  Minverter = 18
  PER = 100p
  SgnP = 0
  TCLK = 100p
  VGA1 = 0
  VGA2 = 0
  VGA3 = 0
  WN = 252n
  WP = 652n
  X1 = 0
  X2 = 0
  X3 = 0
