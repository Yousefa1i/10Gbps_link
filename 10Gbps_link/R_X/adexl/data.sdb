ADE simulation setup
Run mode: Single Run, Sweeps and Corners
Tests:
  Project1:R_X:1: Project1/R_X/schematic, simulator spectre
Global variables:
  L = 470n
  W = 500n
