ADE simulation setup
Run mode: Single Run, Sweeps and Corners
Tests:
  Proj_1:TEST4:1: Proj_1/TEST4/schematic, simulator spectre
Global variables:
  Minverter = 18
  M = 8
  Mlvt = 30
  WN = 252n
  WP = 652n
  VDD = 1.2
  M_3rd_Stage = 8
  M_predriver = 30
  M_MUX = 1
  M_TG = 3
