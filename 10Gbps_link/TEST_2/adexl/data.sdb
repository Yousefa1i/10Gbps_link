ADE simulation setup
Run mode: Single Run, Sweeps and Corners
Tests:
  Proj_1:TEST_2:1: Proj_1/TEST_2/schematic, simulator spectre
Global variables:
  M = 1
  VDD = 1.2
Corners:
  model folders: /home/cadence/Desktop/Seriallinks/tsmc65nm/tsmcN65/../models/spectre
  PVT: temperature=-40 125; VDD=1.08 1.32; crn65gplus_2d5_lk_v1d0.scs[ss_res ff_res]
