ADE simulation setup
Run mode: Single Run, Sweeps and Corners
Tests:
  Proj_1:TEST_3:1: Proj_1/TEST_3/schematic, simulator spectre
    Outputs: ronN
Global variables:
  WN = 1.9u
  WP = 5.75u
  VDD = 1.2
  M = 1
  L = 88.41u
Corners:
  model folders: /home/cadence/Desktop/Seriallinks/tsmc65nm/tsmcN65/../models/spectre
  C0: temperature=-40 125; VDD=1.08 1.32; crn65gplus_2d5_lk_v1d0.scs[ff_res  ss_res]
