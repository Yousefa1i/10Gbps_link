ADE simulation setup
Run mode: Single Run, Sweeps and Corners
Tests:
  Proj_1:TSPC_flip_flop_TB:1: Proj_1/TSPC_flip_flop_TB/schematic, simulator spectre
Global variables:
  M = 80
