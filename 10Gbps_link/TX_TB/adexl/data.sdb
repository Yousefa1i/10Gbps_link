ADE simulation setup
Run mode: Single Run, Sweeps and Corners
Tests:
  new_tx:TX_TB:1: new_tx/TX_TB/schematic, simulator spectre
Global variables:
  Mlvt = 30
  M = 8
  Minverter = 18
  M_3rd_Stage = 8
  M_MUX = 1
  M_predriver = 25
  M_TG = 1
  VDD = 1.2
  WN = 252n
  WP = 652n
