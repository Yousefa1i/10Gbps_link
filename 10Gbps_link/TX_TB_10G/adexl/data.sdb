ADE simulation setup
Run mode: Single Run, Sweeps and Corners
Tests:
  Proj_1:TX_TB_10G:1: Proj_1/TX_TB_10G/schematic, simulator spectre
Global variables:
  M = 8
  M_3rd_Stage = 8
  M_MUX = 1
  M_predriver = 30
  M_TG = 1
  Minverter = 18
  VDD = 1.2
  WN = 252n
  WP = 652n
  M_TG_EN = 2
