ADE simulation setup
Run mode: Single Run, Sweeps and Corners
Tests:
  Proj_1:TX_TB_NO_FFE:1: Proj_1/TX_TB_NO_FFE/schematic, simulator spectre
    Outputs: TX_vodiff; ((VT("/TXP") + VT("/TXN")) / 2); RX_vodiff
Global variables:
  M = 8
  M_3rd_Stage = 8
  M_predriver = 30
  Minverter = 18
  VDD = 1.2
  WN = 484n
  WP = 1.3985u
