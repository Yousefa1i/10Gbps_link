ADE simulation setup
Run mode: Single Run, Sweeps and Corners
Tests:
  Proj_1:TX_TB_V2:1: Proj_1/TX_TB_V2/schematic, simulator spectre
    Outputs: ""; Vodiff_TX; VOCM; Vodiff_RX; (VT("/RX_P") - VT("/RX_N"))
Global variables:
  M = 10
  Minverter = 26
  VDD = 1.2
  WN = 1.9u
  WP = 5.75u
