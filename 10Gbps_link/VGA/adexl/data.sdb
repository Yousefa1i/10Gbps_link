ADE simulation setup
Run mode: Single Run, Sweeps and Corners
Tests:
  Project1:VGA:1: Project1/VGA/schematic, simulator spectre
Global variables:
  CL = 40f
  RE = 20
