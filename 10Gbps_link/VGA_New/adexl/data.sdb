ADE simulation setup
Run mode: Single Run, Sweeps and Corners
Tests:
  Project1:VGA_New:1: Project1/VGA_New/schematic, simulator spectre
Global variables:
  RE = 20
