ADE simulation setup
Run mode: Single Run, Sweeps and Corners
Tests:
  pro_2:VGA_TB:1: pro_2/VGA_TB/schematic, simulator spectre
Global variables:
  CONT_1 = 0,1
  CONT_2 = 0,1
  CONT_3 = 0,1
  VCM = 0.6
  VDD = 1.2
  RA = 10 (off)
  W = 33u
  w1 = 4.8u
  WM = 2.6u
  L = 60n
