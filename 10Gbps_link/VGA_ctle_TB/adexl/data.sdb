ADE simulation setup
Run mode: Single Run, Sweeps and Corners
Tests:
  serdes_project:VGA_ctle_TB:1: serdes_project/VGA_ctle_TB/schematic, simulator spectre
Global variables:
  VGA1 = 0
  VGA2 = 0
  VGA3 = 1
  X1 = 1
  X2 = 1
  X3 = 0
  TCLK = 100p
