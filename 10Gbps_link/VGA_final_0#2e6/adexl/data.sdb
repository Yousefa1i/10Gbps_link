ADE simulation setup
Run mode: Single Run, Sweeps and Corners
Tests:
  Project1:VGA_final_0.6:1: Project1/VGA_final_0.6/schematic, simulator spectre
Global variables:
  CL = 40p
  RE = 20
