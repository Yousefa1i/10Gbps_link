ADE simulation setup
Run mode: Single Run, Sweeps and Corners
Tests:
  Project1:VGA_gmid:1: Project1/VGA_gmid/schematic, simulator spectre
    Outputs: Nmos_ID/W; Nmos_gm/cgg; Nmos_VGS; Pmos_gm*ro; Pmos_ID/W; Pmos_gm/cgg; Pmos_VGS; Pmos_Vdsat; Nmos_Vdsat
Global variables:
  VGS = 0.4
  L = 60n
  W = 500n
  VDS = 0.4
