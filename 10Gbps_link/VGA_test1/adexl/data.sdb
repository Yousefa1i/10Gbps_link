ADE simulation setup
Run mode: Single Run, Sweeps and Corners
Tests:
  Project1:VGA_test1:1: Project1/VGA_test1/schematic, simulator spectre
Global variables:
  CL = 40p
