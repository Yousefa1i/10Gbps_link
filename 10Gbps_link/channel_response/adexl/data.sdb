ADE simulation setup
Run mode: Single Run, Sweeps and Corners
Tests:
  Proj_1:channel_response:1: Proj_1/channel_response/schematic, simulator spectre
