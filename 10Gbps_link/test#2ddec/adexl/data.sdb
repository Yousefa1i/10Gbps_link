ADE simulation setup
Run mode: Single Run, Sweeps and Corners
Tests:
  AMS:test-dec:1: AMS/test-dec/schematic, simulator spectre
