ADE simulation setup
Run mode: Single Run, Sweeps and Corners
Tests:
  Proj_1:test_ser:1: Proj_1/test_ser/schematic, simulator spectre
Global variables:
  M = 10
  Minverter = 20
