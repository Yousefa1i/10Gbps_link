ADE simulation setup
Run mode: Single Run, Sweeps and Corners
Tests:
  serdes_project:trem_50ohm:1: serdes_project/trem_50ohm/schematic, simulator spectre
Global variables:
  L = 780n
  R = 4870
  W = 1u
